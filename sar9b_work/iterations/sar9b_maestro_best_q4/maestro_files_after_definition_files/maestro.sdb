ADE simulation setup
Run mode: Single Run, Sweeps and Corners
Tests:
  Vcmbased_ADC_tb_1: SAR9B_400MV/ADC_9B_tb_best_q4/schematic, simulator spectre
    Variables: fs = 400M; Vpk = 800m; Cunit = 1f; Vth_sw = 0.9; TSTOP = 2.7u
    Outputs: spectrum_enob; spectrum_sinad
Global variables:
  fs = 400M
  Vpk = 450m
  Cunit = 1f
  TSTOP = 2.7u
