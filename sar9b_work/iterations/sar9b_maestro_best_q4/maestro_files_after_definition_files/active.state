ADE simulation setup
Test Vcmbased_ADC_tb_1: SAR9B_400MV/ADC_9B_tb_best_q4/schematic, simulator spectre
  Models: /home/IC/Desktop/Project/project_tsmcN28_NEW/project_tsmcN28_NEW/iPDK_CRN28HPC+_v1.0_2p2a_20160226_all/CRN28HPCp/models/spectre/toplevel.scs[top_tt]
  Variables: fs = 400M; Vpk = 800m; Cunit = 1f; Vth_sw = 0.9; TSTOP = 2.7u
  Temperature: 27
  Files: definitions /home/IC/Desktop/Project/SAR9B_400MV/DAC8b_va/veriloga/veriloga.va /home/IC/Desktop/Project/SAR9B_400MV/decode_redun9to8/veriloga/veriloga.va
  Analysis tran: stop=VAR("TSTOP") errpreset=moderate
  Output v /out; tran (V) = vtime('tran "/out")
  Output spectrum_v /out; tran (V) = db20(dft(vtime('tran "/out") 2.6e-08 2.586e-06 1024 "Rectangular" 0 0 1))
  Output spectrum_enob = spectrumMeasurement(v("/out" ?result "tran") t 2.6e-08 2.586e-06 1024 390600 2e+08 0 "Rectangular" 0 0 1 "enob")
  Output spectrum_sinad = spectrumMeasurement(v("/out" ?result "tran") t 2.6e-08 2.586e-06 1024 390600 2e+08 0 "Rectangular" 0 0 1 "sinad")
  Output v /VIP; tran (V) = vtime('tran "/VIP")
Run mode: Single Run, Sweeps and Corners
Global variables:
  fs = 400M
  Vpk = 450m
  Cunit = 1f
  TSTOP = 2.7u
