// Generated SAR9B Verilog-A AHDL include wrapper.
simulator lang=spectre
ahdl_include "/home/IC/Desktop/Project/SAR9B_400MV/DAC9b_va/veriloga/veriloga.va"
