// Design: SAR9B_400MV/TB_SUBMOD_COMPARATOR_PERF
simulator lang=spectre
global 0
parameters cload=2f vdiff=10m vcm=450m vdd=900m
include "/home/IC/Desktop/Project/project_tsmcN28_NEW/project_tsmcN28_NEW/iPDK_CRN28HPC+_v1.0_2p2a_20160226_all/CRN28HPCp/models/spectre/toplevel.scs" section=top_tt

// SAR9B_400MV/COMPARATOR/schematic
subckt COMPARATOR CLKC VDD VN VON VOP VP VSS
    M15 (VOP VAN1 VDD VDD) pch_mac l=30n w=2u multi=1 nf=2
    M13 (VON VAP1 VDD VDD) pch_mac l=30n w=2u multi=1 nf=2
    M12 (VAP1 VAN VDD VDD) pch_mac l=30n w=2u multi=1 nf=2
    M9 (VAP1 VAN1 VDD VDD) pch_mac l=30n w=2u multi=1 nf=2
    M8 (VAN1 VAP VDD VDD) pch_mac l=30n w=2u multi=1 nf=2
    M5 (VAN1 VAP1 VDD VDD) pch_mac l=30n w=2u multi=1 nf=2
    M18 (VAP VN net2 VDD) pch_mac l=30n w=2u multi=1 nf=2
    M0 (net2 CLKC VDD VDD) pch_mac l=30n w=2u multi=1 nf=2
    M2 (VAN VP net2 VDD) pch_mac l=30n w=2u multi=1 nf=2
    M16 (VOP VAN1 VSS VSS) nch_mac l=30n w=1u multi=1 nf=1
    M14 (VON VAP1 VSS VSS) nch_mac l=30n w=1u multi=1 nf=1
    M11 (VAP1 VAN net8 VSS) nch_mac l=30n w=1u multi=1 nf=1
    M10 (net8 VAN1 VSS VSS) nch_mac l=30n w=1u multi=1 nf=1
    M7 (VAN1 VAP net6 VSS) nch_mac l=30n w=1u multi=1 nf=1
    M6 (net6 VAP1 VSS VSS) nch_mac l=30n w=1u multi=1 nf=1
    M1 (VAP CLKC VSS VSS) nch_mac l=30n w=1u multi=1 nf=1
    M3 (VAN CLKC VSS VSS) nch_mac l=30n w=1u multi=1 nf=1
ends COMPARATOR

// SAR9B_400MV/TB_SUBMOD_COMPARATOR_PERF/schematic
VVN (VN VSS) vsource dc=vcm-vdiff/2 type=dc
VVP (VP VSS) vsource dc=vcm+vdiff/2 type=dc
VSS_SRC (VSS 0) vsource dc=0 type=dc
VDD_SRC (VDD VSS) vsource dc=vdd type=dc
XCOMP (CLKC VDD VN VON VOP VP VSS) COMPARATOR
VCLK (CLKC VSS) vsource type=pulse val0=0 val1=vdd period=5n delay=1n rise=5p fall=5p width=2n
C_VON (VON VSS) capacitor c=cload
C_VOP (VOP VSS) capacitor c=cload
simulatorOptions options temp=27
tran tran stop=8n errpreset=moderate
save CLKC VP VN VOP VON
