// Design: SAR9B_400MV/TB_SUBMOD_CLK_NOOVERLAP_PERF
simulator lang=spectre
global 0
parameters cload=2f vdd=900m
include "/home/IC/Desktop/Project/project_tsmcN28_NEW/project_tsmcN28_NEW/iPDK_CRN28HPC+_v1.0_2p2a_20160226_all/CRN28HPCp/models/spectre/toplevel.scs" section=top_tt

// SAR9B_400MV/INVX1/schematic
subckt INVX1 IN VDD VSS ZN
    M0 (ZN IN VSS VSS) nch_mac l=30n w=100n multi=1 nf=1
    M1 (ZN IN VDD VDD) pch_mac l=30n w=200n multi=1 nf=1
ends INVX1

// SAR9B_400MV/NAND2X1/schematic
subckt NAND2X1 A B VDD VSS ZN
    M3 (ZN A net1 VSS) nch_mac l=30n w=100n multi=1 nf=1
    M0 (net1 B VSS VSS) nch_mac l=30n w=100n multi=1 nf=1
    M2 (ZN B VDD VDD) pch_mac l=30n w=200n multi=1 nf=1
    M1 (ZN A VDD VDD) pch_mac l=30n w=200n multi=1 nf=1
ends NAND2X1

// SAR9B_400MV/INVX8/schematic
subckt INVX8 IN VDD VSS ZN
    M0 (ZN IN VSS VSS) nch_mac l=30n w=800n multi=1 nf=2
    M1 (ZN IN VDD VDD) pch_mac l=30n w=1.6u multi=1 nf=2
ends INVX8

// SAR9B_400MV/INVX4/schematic
subckt INVX4 IN VDD VSS ZN
    M0 (ZN IN VSS VSS) nch_mac l=30n w=400n multi=1 nf=1
    M1 (ZN IN VDD VDD) pch_mac l=30n w=800n multi=1 nf=1
ends INVX4

// SAR9B_400MV/DELAY_1/schematic
subckt DELAY_1 IN VDD VSS Z
    M4 (Z net1 VSS VSS) nch_mac l=100n w=100n multi=1 nf=1
    M0 (net1 IN VSS VSS) nch_mac l=100n w=100n multi=1 nf=1
    M5 (Z net1 VDD VDD) pch_mac l=100n w=200n multi=1 nf=1
    M1 (net1 IN VDD VDD) pch_mac l=100n w=200n multi=1 nf=1
ends DELAY_1

// SAR9B_400MV/TRIGATEX1/schematic
subckt TRIGATEX1 IN OE OEN VDD VSS Z
    M0 (IN OE Z VSS) nch_mac l=30n w=100n multi=1 nf=1
    M2 (IN OEN Z VDD) pch_mac l=30n w=200n multi=1 nf=1
ends TRIGATEX1

// SAR9B_400MV/CLK_NOOVERLAP/schematic
subckt CLK_NOOVERLAP CLKIN CLKON CLKOP VDD VSS
    I11 (net4 VDD VSS net13) INVX1
    I8 (CLKIN VDD VSS net10) INVX1
    I4 (net6 VDD VSS net7) INVX1
    I2 (net2 VDD VSS net3) INVX1
    I0 (CLKIN VDD VSS net2) INVX1
    I10 (net6 net11 VDD VSS net12) NAND2X1
    I3 (net3 net4 VDD VSS net5) NAND2X1
    I17 (net14 VDD VSS CLKON) INVX8
    I16 (net8 VDD VSS CLKOP) INVX8
    I13 (net13 VDD VSS net14) INVX4
    I6 (net7 VDD VSS net8) INVX4
    I12 (net12 VDD VSS net4) DELAY_1
    I5 (net5 VDD VSS net6) DELAY_1
    I15 (net10 VDD VSS VDD VSS net11) TRIGATEX1
ends CLK_NOOVERLAP

// SAR9B_400MV/TB_SUBMOD_CLK_NOOVERLAP_PERF/schematic
VSS_SRC (VSS 0) vsource dc=0 type=dc
VDD_SRC (VDD VSS) vsource dc=vdd type=dc
XNO (CLKIN CLKON CLKOP VDD VSS) CLK_NOOVERLAP
VCLK (CLKIN VSS) vsource type=pulse val0=0 val1=vdd period=5n delay=500p rise=5p fall=5p width=2n
C_CLKON (CLKON VSS) capacitor c=cload
C_CLKOP (CLKOP VSS) capacitor c=cload
simulatorOptions options temp=27
tran tran stop=12n errpreset=moderate
save CLKIN CLKOP CLKON
