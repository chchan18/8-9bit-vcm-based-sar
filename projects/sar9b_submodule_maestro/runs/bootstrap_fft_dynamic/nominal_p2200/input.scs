// Design: SAR9B_400MV/TB_SUBMOD_BOOTSTRAP_DIFF_FFT
simulator lang=spectre
global 0
parameters cload=5f TSTOP=2.7u fft_n=1024 fft_bin=7 fs=400M Vpk=800m vcm=450m vdd=900m
include "/home/IC/Desktop/Project/project_tsmcN28_NEW/project_tsmcN28_NEW/iPDK_CRN28HPC+_v1.0_2p2a_20160226_all/CRN28HPCp/models/spectre/toplevel.scs" section=top_tt

// SAR9B_400MV/BOOTSTRAP_DIFF/schematic
subckt BOOTSTRAP_DIFF CLKS CLKSB VDD VIN VIP VOUTN VOUTP VSS
    M35 (VIP VSS VOUTN VSS) nch_mac l=30n w=1u multi=2 nf=1
    M34 (VIN VSS VOUTP VSS) nch_mac l=30n w=1u multi=2 nf=1
    M32 (net6 CLKSB VSS VSS) nch_mac l=30n w=400n multi=1 nf=1
    M31 (NG VDD net6 VSS) nch_mac l=30n w=200n multi=1 nf=1
    M27 (net4 CLKS B B) nch_mac l=30n w=400n multi=1 nf=1
    M26 (net4 NG B VSS) nch_mac l=30n w=210.0n multi=1 nf=1
    M25 (B NG VIN VSS) nch_mac l=30n w=500n multi=1 nf=1
    M24 (B CLKSB VSS VSS) nch_mac l=30n w=2u multi=1 nf=2
    M23 (VIN NG VOUTN B) nch_mac l=30n w=1u multi=2 nf=1
    M9 (VIP PG VOUTP A) nch_mac l=30n w=1u multi=2 nf=1
    M8 (A PG VIP VSS) nch_mac l=30n w=500n multi=1 nf=1
    M7 (net1 PG A VSS) nch_mac l=30n w=210.0n multi=1 nf=1
    M5 (net2 CLKSB VSS VSS) nch_mac l=30n w=400n multi=1 nf=1
    M4 (PG VDD net2 VSS) nch_mac l=30n w=200n multi=1 nf=1
    M3 (A CLKSB VSS VSS) nch_mac l=30n w=2u multi=1 nf=2
    M0 (net1 CLKS A A) nch_mac l=30n w=400n multi=1 nf=1
    M33 (net6 CLKSB VDD VDD) pch_mac l=30n w=200n multi=1 nf=1
    M30 (VDD NG net5 net5) pch_mac l=30n w=2u multi=1 nf=2
    M29 (NG net4 net5 net5) pch_mac l=30n w=500n multi=1 nf=1
    M28 (net4 CLKS VDD VDD) pch_mac l=30n w=800n multi=1 nf=1
    M12 (net2 CLKSB VDD VDD) pch_mac l=30n w=200n multi=1 nf=1
    M6 (PG net1 net3 net3) pch_mac l=30n w=500n multi=1 nf=1
    M2 (VDD PG net3 net3) pch_mac l=30n w=2u multi=1 nf=2
    M1 (net1 CLKS VDD VDD) pch_mac l=30n w=800n multi=1 nf=1
    C2 (net5 B) cfmom_2t nr=70 lr=10u w=50n s=50n stm=1 spm=7 multi=1
    C0 (net3 A) cfmom_2t nr=70 lr=10u w=50n s=50n stm=1 spm=7 multi=1
ends BOOTSTRAP_DIFF

// analogLib/ideal_balun/schematic
subckt ideal_balun d c p n
    K0 (d 0 p c) transformer n1=2
    K1 (d 0 c n) transformer n1=2
ends ideal_balun

// SAR9B_400MV/TB_SUBMOD_BOOTSTRAP_DIFF_FFT/schematic
VCM_SRC (VCM VSS) vsource dc=vcm type=dc
VSS_SRC (VSS 0) vsource dc=0 type=dc
VDD_SRC (VDD VSS) vsource dc=vdd type=dc
XBOOT (CLKS CLKSB VDD VIN VIP VOUTN VOUTP VSS) BOOTSTRAP_DIFF
VCLKSB (CLKSB VSS) vsource type=pulse val0=vdd val1=0 period=1/fs delay=1p rise=1p fall=1p width=0.2/fs
VCLKS (CLKS VSS) vsource type=pulse val0=0 val1=vdd period=1/fs delay=1p rise=1p fall=1p width=0.2/fs
IBAL (VIN_DRV VCM VIP VIN) ideal_balun
C_VOUTN (VOUTN VSS) capacitor c=cload
C_VOUTP (VOUTP VSS) capacitor c=cload
VSIN (VIN_DRV VSS) vsource type=sine delay=50p freq=(fft_bin/fft_n)*fs ampl=Vpk sinedc=0
simulatorOptions options temp=27
tran tran stop=TSTOP errpreset=moderate
save CLKS CLKSB VIP VIN VOUTP VOUTN
