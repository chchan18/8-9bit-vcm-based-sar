// Design: SAR9B_400MV/TB_SUBMOD_ASYCTRL_9CLK_PERF
simulator lang=spectre
global 0
parameters valid_per=2.5n valid_pw=1n valid_td=500p cload=3f vdd=900m
include "/home/IC/Desktop/Project/project_tsmcN28_NEW/project_tsmcN28_NEW/iPDK_CRN28HPC+_v1.0_2p2a_20160226_all/CRN28HPCp/models/spectre/toplevel.scs" section=top_tt

// SAR9B_400MV/NAND2X1/schematic
subckt NAND2X1 A B VDD VSS ZN
    M3 (ZN A net1 VSS) nch_mac l=30n w=100n multi=1 nf=1
    M0 (net1 B VSS VSS) nch_mac l=30n w=100n multi=1 nf=1
    M2 (ZN B VDD VDD) pch_mac l=30n w=200n multi=1 nf=1
    M1 (ZN A VDD VDD) pch_mac l=30n w=200n multi=1 nf=1
ends NAND2X1

// SAR9B_400MV/TRIGATEX1/schematic
subckt TRIGATEX1 IN OE OEN VDD VSS Z
    M0 (IN OE Z VSS) nch_mac l=30n w=100n multi=1 nf=1
    M2 (IN OEN Z VDD) pch_mac l=30n w=200n multi=1 nf=1
ends TRIGATEX1

// SAR9B_400MV/NOR2X1/schematic
subckt NOR2X1 A B VDD VSS ZN
    M3 (ZN A VSS VSS) nch_mac l=30n w=100n multi=1 nf=1
    M0 (ZN B VSS VSS) nch_mac l=30n w=100n multi=1 nf=1
    M2 (ZN B net2 VDD) pch_mac l=30n w=200n multi=1 nf=1
    M1 (net2 A VDD VDD) pch_mac l=30n w=200n multi=1 nf=1
ends NOR2X1

// SAR9B_400MV/INVX1/schematic
subckt INVX1 IN VDD VSS ZN
    M0 (ZN IN VSS VSS) nch_mac l=30n w=100n multi=1 nf=1
    M1 (ZN IN VDD VDD) pch_mac l=30n w=200n multi=1 nf=1
ends INVX1

// SAR9B_400MV/INVX2/schematic
subckt INVX2 IN VDD VSS ZN
    M0 (ZN IN VSS VSS) nch_mac l=30n w=200n multi=1 nf=1
    M1 (ZN IN VDD VDD) pch_mac l=30n w=400n multi=1 nf=1
ends INVX2

// SAR9B_400MV/INVX4/schematic
subckt INVX4 IN VDD VSS ZN
    M0 (ZN IN VSS VSS) nch_mac l=30n w=400n multi=1 nf=1
    M1 (ZN IN VDD VDD) pch_mac l=30n w=800n multi=1 nf=1
ends INVX4

// SAR9B_400MV/DFFRN/schematic
subckt DFFRN CLK D Q RN VDD VSS
    I0 (R net3 VDD VSS net2) NAND2X1
    I14 (D CLKP CLKN VDD VSS net3) TRIGATEX1
    I15 (net3 CLKN CLKP VDD VSS net9) TRIGATEX1
    I4 (net2 CLKN CLKP VDD VSS net8) TRIGATEX1
    I1 (net8 CLKP CLKN VDD VSS net1) TRIGATEX1
    I5 (RN net8 VDD VSS net6) NOR2X1
    I11 (net6 VDD VSS net7) INVX1
    I13 (CLK VDD VSS CLKP) INVX2
    I10 (RN VDD VSS R) INVX2
    I9 (CLKP VDD VSS CLKN) INVX2
    I7 (net6 VDD VSS net1) INVX2
    I2 (net2 VDD VSS net9) INVX2
    I12 (net7 VDD VSS Q) INVX4
ends DFFRN

// SAR9B_400MV/OR3X1/schematic
subckt OR3X1 A B C VDD VSS Z
    M9 (Z net3 VSS VSS) nch_mac l=30n w=400n multi=1 nf=1
    M5 (net3 B VSS VSS) nch_mac l=30n w=400n multi=1 nf=1
    M3 (net3 A VSS VSS) nch_mac l=30n w=400n multi=1 nf=1
    M8 (net3 C VSS VSS) nch_mac l=30n w=400n multi=1 nf=1
    M10 (Z net3 VDD VDD) pch_mac l=30n w=400n multi=1 nf=1
    M7 (net3 C net1 VDD) pch_mac l=30n w=400n multi=1 nf=1
    M6 (net1 B net2 VDD) pch_mac l=30n w=400n multi=1 nf=1
    M1 (net2 A VDD VDD) pch_mac l=30n w=400n multi=1 nf=1
ends OR3X1

// SAR9B_400MV/Asycontrol_logic_9clk/schematic
subckt Asycontrol_logic_9clk CLKC CLKO\<8\> CLKO\<7\> CLKO\<6\> CLKO\<5\> CLKO\<4\> CLKO\<3\> CLKO\<2\> CLKO\<1\> CLKO\<0\> CLKS VALID VDD VSS
    I11 (VALID CLKO\<8\> CLKO\<7\> CLKS VDD VSS) DFFRN
    I7 (VALID CLKO\<1\> CLKO\<0\> CLKS VDD VSS) DFFRN
    I6 (VALID CLKO\<2\> CLKO\<1\> CLKS VDD VSS) DFFRN
    I5 (VALID CLKO\<3\> CLKO\<2\> CLKS VDD VSS) DFFRN
    I4 (VALID CLKO\<4\> CLKO\<3\> CLKS VDD VSS) DFFRN
    I3 (VALID CLKO\<5\> CLKO\<4\> CLKS VDD VSS) DFFRN
    I2 (VALID CLKO\<6\> CLKO\<5\> CLKS VDD VSS) DFFRN
    I1 (VALID CLKO\<7\> CLKO\<6\> CLKS VDD VSS) DFFRN
    I0 (VALID VDD CLKO\<8\> CLKS VDD VSS) DFFRN
    I10 (CLKS VALID CLKO\<0\> VDD VSS CLKC) OR3X1
ends Asycontrol_logic_9clk

// SAR9B_400MV/TB_SUBMOD_ASYCTRL_9CLK_PERF/schematic
VSS_SRC (VSS 0) vsource dc=0 type=dc
VDD_SRC (VDD VSS) vsource dc=vdd type=dc
XASY (CLKC CLKO\<8\> CLKO\<7\> CLKO\<6\> CLKO\<5\> CLKO\<4\> CLKO\<3\> CLKO\<2\> CLKO\<1\> CLKO\<0\> CLKS VALID VDD VSS) Asycontrol_logic_9clk
VVALID (VALID VSS) vsource type=pulse val0=0 val1=vdd period=valid_per delay=valid_td rise=5p fall=5p width=valid_pw
VCLKS (CLKS VSS) vsource type=pulse val0=vdd val1=0 period=100n delay=100p rise=5p fall=5p width=99n
C_CLKC (CLKC VSS) capacitor c=cload
simulatorOptions options temp=27
tran tran stop=28n errpreset=moderate
save CLKS VALID CLKC CLKO\<0\> CLKO\<1\> CLKO\<2\> CLKO\<3\> CLKO\<4\> CLKO\<5\> CLKO\<6\> CLKO\<7\> CLKO\<8\>
